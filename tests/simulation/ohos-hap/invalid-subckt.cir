Invalid fixture for recovery test
Xmissing in 0 undefined_model
.tran 10u 7m
.end
